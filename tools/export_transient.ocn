; Export a saved Spectre transient signal without resampling.
procedure(portfolioExportTransient()
  let((directory signal wave times values count index out)
    directory=getShellEnvVar("PORTFOLIO_RESULT_DIR")
    signal=getShellEnvVar("PORTFOLIO_SIGNAL")
    unless(directory && signal error("Set PORTFOLIO_RESULT_DIR and PORTFOLIO_SIGNAL.\n"))
    openResults(strcat(directory "/psf"))
    unless(member('tran results()) error("Transient result is missing.\n"))
    selectResult('tran)
    wave=getData(signal ?result 'tran)
    unless(wave error("Saved signal is missing: %s\n" signal))
    times=drGetWaveformXVec(wave)
    values=drGetWaveformYVec(wave)
    count=drVectorLength(times)
    unless(count > 1 && count == drVectorLength(values)
      error("Malformed transient vectors.\n"))
    out=outfile(strcat(directory "/selected_signal.csv") "w")
    unless(out error("Cannot open the output CSV.\n"))
    fprintf(out "time_s,value\n")
    for(index 0 count-1
      fprintf(out "%.17g,%.17g\n" drGetElem(times index) drGetElem(values index)))
    close(out)
    printf("PORTFOLIO_TRANSIENT_EXPORT rows=%d signal=%s\n" count signal)
    t
  )
)
if(errset(portfolioExportTransient() t) then exit(0) else exit(1))
